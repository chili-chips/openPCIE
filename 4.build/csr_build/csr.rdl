// SPDX-FileCopyrightText: 2026 Chili.CHIPS
//
// SPDX-License-Identifier: BSD-3-Clause

//==========================================================================
// openPCIE * NLnet-sponsored open-source implementation
//--------------------------------------------------------------------------
//                   Copyright (C) 2026 Chili.CHIPS
//
// Redistribution and use in source and binary forms, with or without
// modification, are permitted provided that the following conditions
// are met:
//
// 1. Redistributions of source code must retain the above copyright
// notice, this list of conditions and the following disclaimer.
//
// 2. Redistributions in binary form must reproduce the above copyright
// notice, this list of conditions and the following disclaimer in the
// documentation and/or other materials provided with the distribution.
//
// 3. Neither the name of the copyright holder nor the names of its
// contributors may be used to endorse or promote products derived
// from this software without specific prior written permission.
//
// THIS SOFTWARE IS PROVIDED BY THE COPYRIGHT HOLDERS AND CONTRIBUTORS "AS
// IS" AND ANY EXPRESS OR IMPLIED WARRANTIES, INCLUDING, BUT NOT LIMITED
// TO, THE IMPLIED WARRANTIES OF MERCHANTABILITY AND FITNESS FOR A
// PARTICULAR PURPOSE ARE DISCLAIMED. IN NO EVENT SHALL THE COPYRIGHT
// HOLDER OR CONTRIBUTORS BE LIABLE FOR ANY DIRECT, INDIRECT, INCIDENTAL,
// SPECIAL, EXEMPLARY, OR CONSEQUENTIAL DAMAGES (INCLUDING, BUT NOT
// LIMITED TO, PROCUREMENT OF SUBSTITUTE GOODS OR SERVICES; LOSS OF USE,
// DATA, OR PROFITS; OR BUSINESS INTERRUPTION) HOWEVER CAUSED AND ON ANY
// THEORY OF LIABILITY, WHETHER IN CONTRACT, STRICT LIABILITY, OR TORT
// (INCLUDING NEGLIGENCE OR OTHERWISE) ARISING IN ANY WAY OUT OF THE USE
// OF THIS SOFTWARE, EVEN IF ADVISED OF THE POSSIBILITY OF SUCH DAMAGE.
//
//              https://opensource.org/license/bsd-3-clause
//--------------------------------------------------------------------------
// Description:
//   This file defines the Control and Status Registers (CSR) of the
//   openPCIE Root Complex SOC -- the TLP transmit/receive window that the
//   RISC-V firmware uses in place of the AMD-proprietary hardware FSM.
//   The layout is openCologne-PCIE's: every TLP, header and payload, goes
//   through a payload window, so a Memory request may carry a burst.
//
//   Register map:
//
//     0x3000_0000  -               free
//     0x3000_000C  tx.send         send N TLPs from tx_payload (W, triggers)
//     0x3000_0010  -               free
//     0x3000_0020  rx.valid        a TLP waits; writing 1 frees it (R, W)
//     0x3000_0024  status.err      fatal error received      (R, W1C)
//     0x3000_0028  status.phy      Tx FSM busy + buffers     (R)
//     0x3000_002C  status.result   firmware result marker    (RW)
//     0x3000_1000  rx_payload      the RX ring's head TLP    (R, 1024 DW)
//     0x3000_2000  tx_payload      the TLPs to send          (W, 1024 DW)
//==========================================================================

addrmap csr {
   name = "csr";
   desc = "openPCIE Root Complex CSR";

   littleendian;
   default accesswidth = 32;
   default regwidth = 32;
   default alignment = 4;
   addressing = compact;

   //-----------------------------------------------------------------------
   // Tx -- the TLPs the CPU hands over to the PCIe link
   //-----------------------------------------------------------------------
   regfile tx {
      name = "csr.tx";
      desc = "TLP Transmit CSR (CPU --> PCIe link). The TLPs go in
              tx_payload, header first; writing tx.send launches them.";

      external reg {
         name = "csr.tx.send";
         desc = "TLP Send -- writing this register STARTS the transfer";

         field {
            name = "csr.tx.send.count[7:0]";
            desc = "The number of TLPs to send. The firmware writes them back
                    to back into tx_payload from entry 0, header first, then
                    their number here, LAST: the Tx FSM sends them in order,
                    each one's length from its DW0 (Fmt and Length).
                    External: nothing is stored, the write starts the FSM.";
            sw = w;
            hw = r;
         } count[7:0] = 0;
      } send @ 0x0C;
   } tx @ 0x00;

   //-----------------------------------------------------------------------
   // Rx -- the TLPs coming in from the link, captured as-is
   //-----------------------------------------------------------------------
   regfile rx {
      name = "csr.rx";
      desc = "TLP Receive CSR (PCIe link --> CPU). Incoming TLPs queue up in
              a ring, as they are. rx_payload shows the oldest, the head:
              entry i is its DW i. The firmware decodes it, then frees it.";

      external reg {
         name = "csr.rx.valid";
         desc = "Receive Status Register";

         field {
            name = "csr.rx.valid.valid";
            desc = "Reads 1 while a TLP is waiting in rx_payload. Writing 1
                    frees it, and the next TLP in the ring takes its place.
                    External: nothing is stored, the ring is the state.";
            sw = rw;
            hw = r;
         } valid[0:0] = 0;
      } valid @ 0x10;
   } rx @ 0x10;

   //-----------------------------------------------------------------------
   // Status -- what the PCIe hard macro and the Tx FSM report
   //-----------------------------------------------------------------------
   regfile status {
      name = "csr.status";
      desc = "PCIe Link Status CSR";

      reg {
         name = "csr.status.err";
         desc = "PCIe Error Status Register";

         field {
            name = "csr.status.err.msg_err_fatal";
            desc = "A fatal-error Message TLP has been received
                    (cfg_msg_received_err_fatal). Sticky: stays 1 until
                    software writes 1 to it";
            sw = rw;
            woclr;
            hw = na;
            hwset;
            precedence = hw;  // an error in the clearing cycle is kept
         } msg_err_fatal[16:16] = 0;
      } err;

      reg {
         name = "csr.status.phy";
         desc = "Tx FSM / PCIe hard macro Status Register";

         field {
            name = "csr.status.phy.tx_busy";
            desc = "The Tx FSM is sending. Software polls for 0 before it
                    writes the next TLPs into tx_payload.";
            sw = r;
            hw = w;
         } tx_busy[0:0] = 0;

         field {
            name = "csr.status.phy.tx_buf_avail[5:0]";
            desc = "Number of free transmit buffers in the PCIe hard macro
                    (tx_buf_avail). Software waits for a non-zero value.";
            sw = r;
            hw = w;
         } tx_buf_avail[13:8] = 0;
      } phy;

      reg {
         name = "csr.status.result";
         desc = "Firmware Result Register";

         field {
            name = "csr.status.result.marker[31:0]";
            desc = "Result marker the firmware writes when it stops, e.g.
                    0x0000FACE for PASS. Unlike tx.send, writing it launches
                    no TLP: the value goes to logic only, to the PASS LED and
                    to an ILA.";
            sw = rw;
            hw = r;
         } marker[32] = 0;
      } result;
   } status @ 0x24;

   //-----------------------------------------------------------------------
   // Payload windows -- every DWORD of a TLP, header first. Each is one
   // RAMB36 (1024 x 32, true dual port): all of one block RAM
   //-----------------------------------------------------------------------
   external mem {
      name = "csr.rx_payload";
      desc = "The head TLP of the RX ring, header first, while rx.valid
              reads 1: entry i is its DW i. The window spans the ring:
              entries past the head show the TLPs behind it.";
      mementries = 1024;
      memwidth = 32;
      sw = r;
   } rx_payload @ 0x1000;

   external mem {
      name = "csr.tx_payload";
      desc = "The TLPs to send, back to back from entry 0, header first:
              entry i is DW i of the batch. Writing their number into tx.send
              then launches them; each one's Fmt and Length say how many
              entries it takes.";
      mementries = 1024;
      memwidth = 32;
      sw = w;
   } tx_payload @ 0x2000;
};

//==========================================================================
// SOC top level -- the address map the RISC-V firmware sees
//==========================================================================
addrmap openpcie {
   littleendian;
   default accesswidth = 32;
   default regwidth = 32;
   default alignment = 4;
   addressing = compact;

   // 8 KB of unified instruction/data RAM, initialised from firmware.hex
   external mem imem {
      name = "imem";
      desc = "CPU Program/Data Memory";
      mementries = 2048;
      memwidth = 32;
   } imem @ 0x0000_0000;

   csr csr @ 0x3000_0000;
};
